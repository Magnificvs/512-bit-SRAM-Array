ADE simulation setup
Run mode: Single Run, Sweeps and Corners
Tests:
  EE577a_S26_4bitRCA_tb_1: EE577a_S26/4bitRCA_tb/schematic, simulator spectre
