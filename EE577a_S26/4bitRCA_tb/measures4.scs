simulator lang=spice
.param vdd=1 vth=0.5
