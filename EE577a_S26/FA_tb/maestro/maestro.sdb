ADE simulation setup
Run mode: Single Run, Sweeps and Corners
Tests:
  EE577a_S26_FA_tb_1: EE577a_S26/FA_tb/schematic, simulator spectre
