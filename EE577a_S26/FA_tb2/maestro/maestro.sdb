ADE simulation setup
Run mode: Single Run, Sweeps and Corners
Tests:
  EE577a_S26_FA_tb2_1: EE577a_S26/FA_tb2/schematic, simulator spectre
    Variables: F = {From/To}Auto:1:7:4{From/To}
