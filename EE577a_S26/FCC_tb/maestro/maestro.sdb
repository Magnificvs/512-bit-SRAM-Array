ADE simulation setup
Run mode: Single Run, Sweeps and Corners
Tests:
  EE577a_S26_FCC1_tb_1: EE577a_S26/FCC_tb/config, simulator spectre
