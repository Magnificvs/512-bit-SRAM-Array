ADE simulation setup
Run mode: Single Run, Sweeps and Corners
Tests:
  EE577a_S26_8bitComp_tb_1: EE577a_S26/8bitComp_tb/config, simulator spectre
