ADE simulation setup
Run mode: Single Run, Sweeps and Corners
Tests:
  EE577a_SRAM_512bit: EE577a_SRAM/SRAM_8x64_SA_WD/schematic, simulator spectre
    Outputs: /CLK; /write_en; "/BL<15:0>"; "/BLB<15>"; "/WL<7>"; /dec_en; "/BL<15>"; "/net9"; "/net20"; "/reset_b"; "/OUT<0>"; "/data_out<0>"; "/WL<0>"; "/data<0>"; "/data_in_b<0>"; "/data_in<0>"; /data_in<0>; "/data_b<0>"; "/c"; "/A<0>"; "/A<2>"; "/A<4>"; /A<4>; /A<3>; /A<2>; /A<1>; /A<0>; /data<15>; /data<14>; /data<13>; /data<12>; /data<11>; /data<10>; "/data<9>"; /data<9>; /data<8>; /data<7>; /data<6>; /data<5>; /data<4>; /data<3>; /data<2>; /data<1>; /data<0>; /data_out<15>; /data_out<14>; /data_out<13>; /data_out<12>; /data_out<11>; /data_out<10>; /data_out<9>; /data_out<8>; /data_out<7>; /data_out<6>; /data_out<5>; /data_out<4>; /data_out<3>; /data_out<2>; /data_out<1>; /data_out<0>
