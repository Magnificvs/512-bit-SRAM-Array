ADE simulation setup
Run mode: Single Run, Sweeps and Corners
Tests:
  EE577a_SRAM_SRAM_1bit_tb_1: EE577a_SRAM/SRAM_1bit_tb/schematic, simulator spectre
    Outputs: /I0/Q; /I0/QB; "/I11/RBL"; "/I11/RBL_b"
