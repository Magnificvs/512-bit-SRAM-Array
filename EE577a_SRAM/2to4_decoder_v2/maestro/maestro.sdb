ADE simulation setup
Run mode: Single Run, Sweeps and Corners
Tests:
  EE577a_SRAM_2to4_decoder_1: EE577a_SRAM/2to4_decoder/schematic, simulator spectre
    Outputs: /CS<3>; /CS<2>; /CS<1>; /CS<0>
