ADE simulation setup
Run mode: Single Run, Sweeps and Corners
Tests:
  EE577a_SRAM_512bit: EE577a_SRAM/SRAM_512b_TB_2/config, simulator spectre
    Outputs: /CLK; /write_en; "/BL<15:0>"; "/BLB<15>"; "/WL<7>"; /dec_en; "/BL<15>"; "/net9"; "/net20"; BL; BLB; "/reset_b"; /reset_b; "/OUT<0>"; "/data_out<0>"; /data_out<0>; "/WL<0>"; /WL<0>; "/data<0>"; "/data_in_b<0>"; "/data_in<0>"; /data_in<0>; "/data_b<0>"; /data<0>; /data_b<0>; "/sa_out<10>"; "/sa_out<0>"; /sa_out<0>
