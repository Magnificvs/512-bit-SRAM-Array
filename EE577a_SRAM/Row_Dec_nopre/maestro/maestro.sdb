ADE simulation setup
Run mode: Single Run, Sweeps and Corners
Tests:
  EE577a_SRAM_Row_decoder_1: EE577a_SRAM/Row_Dec_nopre/schematic, simulator spectre
    Outputs: "/WL<0>"; "/WL<1>"; "/WL<2>"; "/WL3"; "/WL<3>"; "/WL<4>"; "/WL<5>"; "/WL<6>"; "/WL<7>"; /EN; "/A<4>"; "/A<3>"; "/A<2>"; "/00xx"; /00xx; /11xx; /WL<0>; /WL<1>; /WL<2>; /WL<3>; /WL<4>; /WL<5>; /WL<6>; /WL<7>; /A<4>; /A<3>; /A<2>
