ADE simulation setup
Run mode: Single Run, Sweeps and Corners
Tests:
  EE577a_SRAM_Row_decoder_1: EE577a_SRAM/Row_Dec/schematic, simulator spectre
    Outputs: "/WL<0>"; "/WL<1>"; "/WL<2>"; "/WL3"; "/WL<3>"; "/WL<4>"; "/WL<5>"; "/WL<6>"; "/WL<7>"; "/dec_en"; "/A<4>"; "/A<3>"; "/A<2>"; "/00xx"; "/WL_en<0>"; "/WL_en<1>"; "/WL_en<2>"; "/WL_en<3>"; "/WL_en<4>"; "/WL_en<5>"; "/WL_en<6>"; "/WL_en<7>"; /A<4>; /A<3>; /A<2>; /dec_en; /WL_en<0>; /WL_en<3>; /WL_en<7>; /WL_en<1>; /WL_en<5>; /out; /WL_en<6>; /WL_en<2>; /WL_en<4>
