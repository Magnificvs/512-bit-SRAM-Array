ADE simulation setup
Run mode: Single Run, Sweeps and Corners
Tests:
  EE577a_SRAM_Column_MUX_tb: EE577a_SRAM/Column_MUX_tb/schematic, simulator spectre
    Outputs: "/BL_b<0>"; "/BL_b<1>"; "/bl2"; "/bl1"; "/D"; "/bl0"; "/blb0"; "/BLLB<0>"; "/sense"; "/blb3"; "/ccs<2>"; "/csb<2>"; "/BLL<0>"; "/blb2"; "/sen_b"; "/cs<3:0>"; "/cs<3>"; "/css<3>"; "/css<0>"; "/css<"; "/css"; "/CS3:0<>"; "/CS<3:0>"; "/CS<20>"; "/CS<2>"; "/css<2>"; "/A1"; "/A0"; "/CS<0>"; /CS<0>; "/ccs<0>"; "/BLL<2>"; /csb<0>; /BLL<0>; "/BLBB<0>"; /BLBB<0>; "/sen"; /sen; /sen_b; /csb<2>; /ccs<2>; "/BLBB<2>"; /BLBB<2>
